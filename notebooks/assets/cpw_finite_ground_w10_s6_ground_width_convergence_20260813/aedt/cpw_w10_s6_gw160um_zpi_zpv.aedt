# Ansys Electronics Desktop project, version 2024.2
materials:
  vacuum: permittivity=1
  air: permittivity=1.0006 permeability=1.0000004
  silicon: permittivity=11.9

design cpw_w10_s6_gw160um_all-conductor-length-1m-ground-fine-zpi-zpv-v2_HFSS_Terminal (HFSS, HFSS Terminal Network, model units um)
geometry:
  signal, finite_ground_1, finite_ground_2 = imported_body(/work/Ansys/fileGUXfvU47386417865586982..x_t)
  substrate [silicon] = imported_body(/work/Ansys/fileGUXfvU47386417865586982..x_t)
  Region [vacuum] = region(absolute_offset: +X=0um, -X=0um, +Y=0um, -Y=0um, +Z=1000um, -Z=1000um)
boundaries and excitations:
  PerfectE: Perfect E Objects=[signal, finite_ground_1, finite_ground_2]
  signal_T1: Terminal port=o1 Edges=signal.edge(at (-250, 0, 0)) TerminalResistance=50ohm
  signal_T2: Terminal port=o2 Edges=signal.edge(at (250, 0, 0)) TerminalResistance=50ohm
  o1: Wave Port Faces=Region.face(-x) WavePortType=Terminal NumModes=1 RenormalizeAllTerminals=false
  o2: Wave Port Faces=Region.face(+x) WavePortType=Terminal NumModes=1 RenormalizeAllTerminals=false
  reference conductors: finite_ground_1, finite_ground_2
mesh:
  cpw_conductor_length_mesh: LengthBased Objects=[signal, finite_ground_1, finite_ground_2] NumMaxElem=1000000 MaxLength=10um
  ground_surface_fine_large: SurfApproxBased Objects=[finite_ground_1, finite_ground_2] CurvedSurfaceApproxChoice=UseSlider SliderMeshSettings=9
setups:
  Setup1: HfssDriven MultipleAdaptiveFreqsSetup{Low=3GHz High=8GHz} MaxDeltaS=0.02 MaximumPasses=99 MinimumPasses=1 MinimumConvergedPasses=2 PercentRefinement=30 BasisOrder=1 PortAccuracy=2 DrivenSolverType="Direct Solver"
    sweep S: 3GHz to 8GHz, 20000 points; Type=Fast
source amplitudes:
  o1:1: 1V 0deg
  o2:1: 0V 0deg

design cpw_w10_s6_gw160um_all-conductor-length-1m-ground-fine-zpi-zpv-v2_HFSS_Modal_Zpv (HFSS, HFSS Modal Network, model units um)
geometry:
  signal, finite_ground_1, finite_ground_2 = imported_body(/work/Ansys/fileGUXfvU47386417865586982..x_t)
  substrate [silicon] = imported_body(/work/Ansys/fileGUXfvU47386417865586982..x_t)
  Region [vacuum] = region(absolute_offset: +X=0um, -X=0um, +Y=0um, -Y=0um, +Z=1000um, -Z=1000um)
boundaries and excitations:
  PerfectE: Perfect E Objects=[signal, finite_ground_1, finite_ground_2]
  o1: Wave Port Faces=Region.face(-x) WavePortType=Modal NumModes=1 Modes{Mode1{IntLine{(-250, 5, 0) -> (-250, 11, 0)} CharImp=Zpv}}
  o2: Wave Port Faces=Region.face(+x) WavePortType=Modal NumModes=1 Modes{Mode1{IntLine{(250, 5, 0) -> (250, 11, 0)} CharImp=Zpv}}
  reference conductors: finite_ground_1, finite_ground_2
mesh:
  cpw_conductor_length_mesh: LengthBased Objects=[signal, finite_ground_1, finite_ground_2] NumMaxElem=1000000 MaxLength=10um
  ground_surface_fine_large: SurfApproxBased Objects=[finite_ground_1, finite_ground_2] CurvedSurfaceApproxChoice=UseSlider SliderMeshSettings=9
setups:
  Setup1: HfssDriven Frequency=5GHz MaxDeltaS=0.02 MaximumPasses=99 MinimumPasses=1 MinimumConvergedPasses=2 PercentRefinement=30 BasisOrder=1 PortAccuracy=2 DrivenSolverType="Direct Solver"
    sweep S: 3GHz to 8GHz, 20000 points; Type=Fast
source amplitudes:
  o1:1: 1W 0deg
  o2:1: 0W 0deg
