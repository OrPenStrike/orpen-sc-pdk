# Ansys Electronics Desktop project, version 2024.2
materials:
  vacuum: permittivity=1
  silicon: permittivity=11.9
  air: permittivity=1.0006 permeability=1.0000004

design straight_bend_lead300um_ground80um_deembed300um_dzo1pct_terminalmodes_seam5p (HFSS, HFSS Terminal Network, model units um)
geometry:
  signal_1, signal_2, finite_ground_1, finite_ground_2, finite_ground_3 = imported_body(/work/Ansys/file8aQ0P4245897417866479602..x_t)
  substrate [silicon] = imported_body(/work/Ansys/file8aQ0P4245897417866479602..x_t)
  Region [vacuum] = region(absolute_offset: +X=0um, -X=0um, +Y=0um, -Y=0um, +Z=1000um, -Z=1000um)
boundaries and excitations:
  PerfectE: Perfect E Objects=[signal_1, signal_2, finite_ground_1, finite_ground_2, finite_ground_3]
  o1: Terminal port=seam Edges=signal_1.edge(at (-300, -11, 0)) TerminalResistance=50ohm
  o2: Terminal port=seam Edges=signal_2.edge(at (-300, 11, 0)) TerminalResistance=50ohm
  g_center: Terminal port=seam Edges=finite_ground_3.edge(at (-300, 0, 0)) TerminalResistance=50ohm
  o3: Terminal port=o3_wave_port Edges=signal_2.edge(at (100, 411, 0)) TerminalResistance=50ohm
  o4: Terminal port=o4_wave_port Edges=signal_1.edge(at (400, -11, 0)) TerminalResistance=50ohm
  seam: Wave Port Faces=Region.face(-x) WavePortType=Terminal NumModes=3 DeembedDist=300um
  o3_wave_port: Wave Port Faces=Region.face(+y) WavePortType=Terminal NumModes=1 DeembedDist=300um
  o4_wave_port: Wave Port Faces=Region.face(+x) WavePortType=Terminal NumModes=1 DeembedDist=300um
  reference conductors: finite_ground_1, finite_ground_2, finite_ground_3
mesh:
  cpw_mtl_conductor_length_mesh: LengthBased Objects=[signal_1, signal_2, finite_ground_1, finite_ground_2, finite_ground_3] NumMaxElem=1000000 MaxLength=7um
  ground_surface_fine_large: SurfApproxBased Objects=[finite_ground_1, finite_ground_2, finite_ground_3] CurvedSurfaceApproxChoice=UseSlider SliderMeshSettings=9
setups:
  Setup1: HfssDriven MultipleAdaptiveFreqsSetup{Low=3GHz High=8GHz} MaxDeltaS=0.02 MaximumPasses=99 MinimumPasses=1 MinimumConvergedPasses=2 PercentRefinement=30 BasisOrder=1 PortAccuracy=1 DrivenSolverType="Direct Solver" SaveAnyFields=false
    sweep S: 3GHz to 8GHz, 20000 points; Type=Fast
source amplitudes:
  seam:1: 1V 0deg
  seam:2, seam:3, o3_wave_port:1, o4_wave_port:1: 0V 0deg
